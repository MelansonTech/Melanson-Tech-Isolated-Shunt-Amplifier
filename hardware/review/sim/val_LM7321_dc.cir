* LM7321 validation
.include "C:/CS Projects Folder/Isolated Shunt Amplifier/hardware/review/models/LM7321_12V.lib"
V12 vp 0 12
Vin p 0 0
X1 p o vp 0 o LM7321_12V
RL o m 10k
Vm m 0 6
.dc Vin 0 12 0.01
.end

* OPA197 validation
.include "C:/CS Projects Folder/Isolated Shunt Amplifier/hardware/review/models/OPA197.LIB"
V12 vp 0 12
Vin p 0 6
X1 p o vp 0 o OPA197
RL o 0 10k
.op
.end

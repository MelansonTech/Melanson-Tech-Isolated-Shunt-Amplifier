* LM7321 validation
.include "C:/CS Projects Folder/Isolated Shunt Amplifier/hardware/review/models/LM7321_12V.lib"
V12 vp 0 12
Vin p 0 6
X1 p o vp 0 o LM7321_12V
RL o 0 10k
.op
.end

* LM7321 validation
.include "C:/CS Projects Folder/Isolated Shunt Amplifier/hardware/review/models/LM7321_12V.lib"
V12 vp 0 12
Vin p 0 6 AC 1
X1 p n vp 0 o LM7321_12V
Rf o n 100k
Rg n m 1k
Vm m 0 6
RL o 0 10k
.ac dec 50 10 100Meg
.end
